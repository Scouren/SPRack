// #57 item 11: the transfer function from vin to the current through
// vmeasure, in the form SPRack writes tf (xf at 0 Hz) with the output a
// probe instead of a node pair; expect 1e-3 (A/V) for vin. dcxf is VACASK's
// name, tried in case Spectre has it too.
simulator lang=spectre
vin (in 0) vsource dc=1
vmeasure (in mid) vsource dc=0
r1 (mid 0) resistor r=1k
xf1 xf freq=0 probe=vmeasure
tf1 dcxf probe=vmeasure
