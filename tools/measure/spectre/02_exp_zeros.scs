// #57 item 2: an explicit 0 in each of an EXP source's four values, beside
// given ones (the seven sources of verification 4.18's zero table). Read
// v(nX) at 10n, 30n and 49n; README gives both readings (a 0 taken as 0, a
// 0 taken as left out: TAU stop/100 = 0.5n, no fall without TD2).
simulator lang=spectre
v1 (n1 0) vsource type=exp val0=0 val1=1 td1=0 tau1=0 td2=0 tau2=0
v2 (n2 0) vsource type=exp val0=0 val1=1 td1=0 tau1=5n td2=0 tau2=0
v3 (n3 0) vsource type=exp val0=0 val1=1 td1=2n tau1=0 td2=20n tau2=5n
v4 (n4 0) vsource type=exp val0=0 val1=1 td1=2n tau1=5n td2=0 tau2=5n
v5 (n5 0) vsource type=exp val0=0 val1=1 td1=2n tau1=5n td2=20n tau2=0
v6 (n6 0) vsource type=exp val0=0 val1=1 td1=0 tau1=5n td2=20n tau2=5n
v7 (n7 0) vsource type=exp val0=0 val1=1 td1=2n tau1=5n td2=0 tau2=0
r1 (n1 0) resistor r=1k
r2 (n2 0) resistor r=1k
r3 (n3 0) resistor r=1k
r4 (n4 0) resistor r=1k
r5 (n5 0) resistor r=1k
r6 (n6 0) resistor r=1k
r7 (n7 0) resistor r=1k
tran1 tran step=2n stop=50n maxstep=0.05n
save n1 n2 n3 n4 n5 n6 n7
