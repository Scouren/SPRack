* #56 item 8 (no-vloop): two voltage sources in parallel. The manual's
* topology rule 1 (User Guide p.92); the grammar: the run stops.
v1 a 0 1
v2 a 0 2
r1 a 0 1k
.op
.tran 1u 1m
.end
