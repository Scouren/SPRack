* #56 item 12: .tf with a current as the output: loaded or refused?
v1 a 0 1
r1 a b 1k
r2 b 0 1k
vm b c 0
r3 c 0 1k
.tf i(vm) v1
.end
