* #56 item 29: MOS levels 4, 5, 6, 9, 55, 56, 57: loaded, and which model
* the listing shows for each (one .alter each).
m1 d g 0 0 mm l=1u w=1u
vd d 0 1
vg g 0 1
.model mm nmos level=4
.op
.alter
.model mm nmos level=5
.alter
.model mm nmos level=6
.alter
.model mm nmos level=9
.alter
.model mm nmos level=55
.alter
.model mm nmos level=56
.alter
.model mm nmos level=57
.end
