* #56 item 14: .width in=72; the current must not change (1 mA).
.width in=72
v1 a 0 1
r1 a 0 1k
.op
.print op i(v1)
.end
