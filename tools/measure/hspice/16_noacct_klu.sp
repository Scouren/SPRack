* #56 item 16: .option noacct and .option klu: loaded, and the current 1 mA.
.option noacct
.option klu
v1 a 0 1
r1 a 0 1k
.op
.print op i(v1)
.end
