* #56 item 8 (no-vlloop): 1 V across an inductor. The manual (User Guide
* p.422): an inductor/voltage source loop error; the grammar: the run stops.
v1 a 0 1
l1 a 0 1u
.op
.tran 1u 1m
.end
