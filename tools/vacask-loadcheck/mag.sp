coupling and line
V1 in 0 dc 0 ac 1 sin(0 1 1meg)
R1 in a 50
L1 a 0 1u
L2 b 0 4u
K1 L1 L2 0.9
R2 b 0 1k
.ac lin 5 1meg 5meg
.tran 0.5n 200n 0 0.5n
.end
