RC low-pass
* a divider with a capacitor
V1 in 0 DC 1 AC 1
R1 in out 1k
C1 out 0 100n $ load
.tran 1u 1m
.end
