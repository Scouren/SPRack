top
.include "inc/sub.sp"
.lib "$PDK/corners.lib" tt
X1 a 0 rdiv
.op
.end
