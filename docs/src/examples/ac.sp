t
R1 a 0 1k
.ac dec 10 1 1meg
.noise v(a) V1 dec 10 1 1meg
.end
